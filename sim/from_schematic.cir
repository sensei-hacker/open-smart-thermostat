* generated from thermostat.kicad_sch Sim.* fields
.include thermostat_models.lib
C10 n_W2 n__260_0_180_49 10n
C11 n_E n__260_0_205_49 10n
C13 n_VCLAMP 0 10u
C14 n_p5V 0 10u
C15 0 n_p3V3 100n
C2 0 n_VRECT_DC 0.1u
C3 n_VRECT_DC 0 100u
C5 n_G n__150_0_155_49 10n
C6 n_Y1 n__150_0_180_49 10n
C7 n_Y2 n__150_0_205_49 10n
C8 n_OB n__150_0_230_49 10n
C9 n_W1 n__260_0_155_49 10n
XD1 n_RC_24VAC_UNFUSED n_VRECT_DC D1N4007
XD10 n__335_28_58_42 0 BZX79C30
XD7 n_RC_24VAC_UNFUSED n_C_24VAC P6KE47CA
R_F1 n_C_24VAC 0 1
R_JP1 n_RH_24VAC n_RC_24VAC_UNFUSED 1m
XQ1 n_RC_24VAC_UNFUSED n_G n__138_92_155_08 BT138
XQ2 n_RC_24VAC_UNFUSED n_Y1 n__138_92_180_08 BT138
XQ3 n_RC_24VAC_UNFUSED n_Y2 n__138_92_205_08 BT138
XQ4 n_RC_24VAC_UNFUSED n_OB n__138_92_230_08 BT138
XQ5 n_RH_24VAC n_W1 n__248_92_155_08 BT138
XQ6 n_RH_24VAC n_W2 n__248_92_180_08 BT138
XQ7 n_RH_24VAC n_E n__248_92_205_08 BT138
XQ8 n__335_28_58_42 n_VRECT_DC n_VCLAMP TIP122
R1 n_p3V3 n_TP_SDA 4.7k
R10 n__150_0_180_49 n_RC_24VAC_UNFUSED 100
R11 n_GP_Y2 n__112_38_200_0 220
R12 n__130_19_205_08 n__138_92_205_08 220
R13 n__150_0_205_49 n_RC_24VAC_UNFUSED 100
R14 n_GP_OB n__112_38_225_0 220
R15 n__130_19_230_08 n__138_92_230_08 220
R16 n__150_0_230_49 n_RC_24VAC_UNFUSED 100
R17 n_GP_W1 n__222_38_150_0 220
R18 n__240_19_155_08 n__248_92_155_08 220
R19 n__260_0_155_49 n_RH_24VAC 100
R2 n_p3V3 n_TP_SCL 4.7k
R20 n_GP_W2 n__222_38_175_0 220
R21 n__240_19_180_08 n__248_92_180_08 220
R22 n__260_0_180_49 n_RH_24VAC 100
R23 n_GP_E n__222_38_200_0 220
R24 n__240_19_205_08 n__248_92_205_08 220
R25 n__260_0_205_49 n_RH_24VAC 100
R26 n_p3V3 n__93_98_167_64 100
R27 n_1WIRE n__93_98_170_18 100
R28 n__335_28_58_42 n_VRECT_DC 2.2k
R4 n_p3V3 n_1WIRE 4.7k
R5 n_GP_G n__112_38_150_0 220
R6 n__130_19_155_08 n__138_92_155_08 220
R7 n__150_0_155_49 n_RC_24VAC_UNFUSED 100
R8 n_GP_Y1 n__112_38_175_0 220
R9 n__130_19_180_08 n__138_92_180_08 220
R_L5 n_p5V 0 62.5
R_LH1 n_Y1 n_C_24VAC 60
R_TX1 n_SIM_VAC n_RC_24VAC_UNFUSED 1.5
XU1 n_VCLAMP 0 n_p5V K7805
XU10 n__222_38_200_0 0 n_E n__240_19_205_08 MOC3063
XU4 n__112_38_150_0 0 n_G n__130_19_155_08 MOC3063
XU5 n__112_38_175_0 0 n_Y1 n__130_19_180_08 MOC3063
XU6 n__112_38_200_0 0 n_Y2 n__130_19_205_08 MOC3063
XU7 n__112_38_225_0 0 n_OB n__130_19_230_08 MOC3063
XU8 n__222_38_150_0 0 n_W1 n__240_19_155_08 MOC3063
XU9 n__222_38_175_0 0 n_W2 n__240_19_180_08 MOC3063
V1 n_SIM_VAC n_C_24VAC SIN(0 34.08 60)
VG1 n_GP_Y1 0 PULSE(0 3.3 0.2 1u 1u 0.3 1)
XXDIAL1 n_p5V 0 DIAL_LOAD
.options method=gear reltol=1e-3
.tran 20u 0.8 0 50u uic
.control
run
set wr_singlescale
wrdata from_schematic.dat v(n_RC_24VAC_UNFUSED) v(n_C_24VAC) v(n_VRECT_DC) v(n_VCLAMP) v(n_p5V) v(n_Y1) v(n_GP_Y1)
quit
.endc
.end
